* REPAIRED STAGE-1 50.000W SELV 4x4 SERIES-PARALLEL SMD-2512 NETLIST (CLOSES F1 & F2)
* 50.000 W IS THE MATRIX DISSIPATION AT ITS BUS TERMINALS (24.0 V). WITH THE 0.020 OHM
* FUSE + 0.010 OHM BIMETAL SERIES PROTECTION THE TOTAL DRAW IS 49.87 W AND MATRIX
* DISSIPATION IS 49.74 W (3.109 W/RESISTOR). SEE repair_coupon.py FOR THE COMPUTATION.
* SAFETY NOTICE: DO NOT ENERGIZE WITHOUT EXTERNAL PE/EHS APPROVAL. STAGE-0 IS INERT ONLY.
.PARAM V_SELV=24.0 R_UNIT=11.52
V_SUPPLY N_RAW_24V 0 DC {V_SELV}
R_FUSE_2_5A N_RAW_24V N_FUSED_24V 0.020
R_BIMETAL_CUTOFF_85C N_FUSED_24V N_BUS_TOP 0.010
R_H_0_0 N_BUS_TOP N_S0_C0 {R_UNIT}
R_H_0_1 N_S0_C0 N_S0_C1 {R_UNIT}
R_H_0_2 N_S0_C1 N_S0_C2 {R_UNIT}
R_H_0_3 N_S0_C2 0 {R_UNIT}
R_H_1_0 N_BUS_TOP N_S1_C0 {R_UNIT}
R_H_1_1 N_S1_C0 N_S1_C1 {R_UNIT}
R_H_1_2 N_S1_C1 N_S1_C2 {R_UNIT}
R_H_1_3 N_S1_C2 0 {R_UNIT}
R_H_2_0 N_BUS_TOP N_S2_C0 {R_UNIT}
R_H_2_1 N_S2_C0 N_S2_C1 {R_UNIT}
R_H_2_2 N_S2_C1 N_S2_C2 {R_UNIT}
R_H_2_3 N_S2_C2 0 {R_UNIT}
R_H_3_0 N_BUS_TOP N_S3_C0 {R_UNIT}
R_H_3_1 N_S3_C0 N_S3_C1 {R_UNIT}
R_H_3_2 N_S3_C1 N_S3_C2 {R_UNIT}
R_H_3_3 N_S3_C2 0 {R_UNIT}
.OP
.END
